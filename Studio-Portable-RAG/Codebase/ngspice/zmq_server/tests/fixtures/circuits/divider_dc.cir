Divider DC sweep
V1 in 0 5
R1 in out 1k
R2 out 0 1k
.dc V1 0 5 0.5
.end
