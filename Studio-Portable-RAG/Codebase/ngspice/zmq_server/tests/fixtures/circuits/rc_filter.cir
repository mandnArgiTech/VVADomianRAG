RC filter DC fixture
V1 in 0 3
R1 in out 2k
C1 out 0 1u
.op
.end
