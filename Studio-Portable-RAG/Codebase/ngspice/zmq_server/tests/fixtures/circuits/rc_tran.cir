RC transient charge
V1 in 0 1
R1 in out 1k
C1 out 0 1u
.ic v(out)=0
.tran 20u 200u uic
.end
