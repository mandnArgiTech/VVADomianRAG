* Simple diode circuit for diagnostic hook testing (Story I)
V1 in 0 5
R1 in out 1k
D1 out 0 D1N4148
.model D1N4148 D(Is=2.52e-9 N=1.752)
.op
.end
